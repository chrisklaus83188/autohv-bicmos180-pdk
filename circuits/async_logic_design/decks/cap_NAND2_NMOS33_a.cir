.title cap_NAND2_a
.include "C:/Users/chris/ngspice/Prompts/autohv_bicmos180_pdk/autohv_bicmos180_case.lib"
.param case=0
.param VDD=3.3
Vdd vdd 0 3.3
V_a a 0 0.0 AC 1
V_b b 0 1.65
X1 out a vdd vdd PMOS33 W={(1.3719)*1e-6} L=0.35u
X2 out b vdd vdd PMOS33 W={(1.3719)*1e-6} L=0.35u
X3 out a n1 0 NMOS33 W={(1.4316)*1e-6} L=0.35u
X4 n1 b 0 0 NMOS33 W={(1.4316)*1e-6} L=0.35u
.control
foreach vb 0 3.3
  alter V_a dc=$vb
  ac lin 1 1e6 1e6
  let cpf = abs(imag(V_a#branch))/6283185.307*1e15
  echo "RES cap=$&cpf"
end
.endc
.end
