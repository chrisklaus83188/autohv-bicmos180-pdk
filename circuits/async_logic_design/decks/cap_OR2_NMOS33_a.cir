.title cap_OR2_a
.include "../../../autohv_bicmos180_case.lib"
.param case=0
.param VDD=3.3
Vdd vdd 0 3.3
V_a a 0 0.0 AC 1
V_b b 0 1.65
X1 p1 a vdd vdd PMOS33 W={(2.9068)*1e-6} L=0.35u
X2 nr b p1 vdd PMOS33 W={(2.9068)*1e-6} L=0.35u
X3 nr a 0 0 NMOS33 W={(0.3000)*1e-6} L=0.35u
X4 nr b 0 0 NMOS33 W={(0.3000)*1e-6} L=0.35u
X5 out nr vdd vdd PMOS33 W={(2.1378)*1e-6} L=0.35u
X6 out nr 0 0 NMOS33 W={(0.6537)*1e-6} L=0.35u
.control
foreach vb 0 3.3
  alter V_a dc=$vb
  ac lin 1 1e6 1e6
  let cpf = abs(imag(V_a#branch))/6283185.307*1e15
  echo "RES cap=$&cpf"
end
.endc
.end
