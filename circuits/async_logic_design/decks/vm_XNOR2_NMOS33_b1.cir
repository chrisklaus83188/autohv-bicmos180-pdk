.title vm_XNOR2_b1
.include "../../../autohv_bicmos180_case.lib"
.param case=0
.param VDD=3.3
Vdd vdd 0 {VDD}
Vin in 0 {VDD/2}
X1 abar in vdd vdd PMOS33 W={(0.9811)*1e-6} L=0.35u
X2 abar in 0 0 NMOS33 W={(0.3000)*1e-6} L=0.35u
X3 bbar vdd vdd vdd PMOS33 W={(0.9811)*1e-6} L=0.35u
X4 bbar vdd 0 0 NMOS33 W={(0.3000)*1e-6} L=0.35u
X5 out in m1 0 NMOS33 W={(0.3000)*1e-6} L=0.35u
X6 m1 bbar 0 0 NMOS33 W={(0.3000)*1e-6} L=0.35u
X7 out abar m2 0 NMOS33 W={(0.3000)*1e-6} L=0.35u
X8 m2 vdd 0 0 NMOS33 W={(0.3000)*1e-6} L=0.35u
X9 out abar k1 vdd PMOS33 W={(1.2367)*1e-6} L=0.35u
X10 k1 bbar vdd vdd PMOS33 W={(1.2367)*1e-6} L=0.35u
X11 out in k2 vdd PMOS33 W={(1.2367)*1e-6} L=0.35u
X12 k2 vdd vdd vdd PMOS33 W={(1.2367)*1e-6} L=0.35u
.control
foreach cs 0 1 2 3 4
 foreach vd 2.970 3.300 3.630
  foreach tp -55 27 150
   alterparam case=$cs
   alterparam VDD=$vd
   reset
   option temp=$tp
   let half=$vd/2
   dc Vin 0 $vd 0.00660
   meas dc vm find v(in) when v(out)=$&half cross=1
   echo "RES cfg=b1 cs=$cs vd=$vd tp=$tp vm=$&vm"
  end
 end
end
.endc
.end
