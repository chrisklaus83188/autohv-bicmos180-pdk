.title vm_XOR2_b0
.include "../../../autohv_bicmos180_case.lib"
.param case=0
.param VDD=1.8
Vdd vdd 0 {VDD}
Vin in 0 {VDD/2}
X1 abar in vdd vdd PMOS18 W={(1.2774)*1e-6} L=0.18u
X2 abar in 0 0 NMOS18 W={(0.2750)*1e-6} L=0.18u
X3 bbar 0 vdd vdd PMOS18 W={(1.2774)*1e-6} L=0.18u
X4 bbar 0 0 0 NMOS18 W={(0.2750)*1e-6} L=0.18u
X5 out in m1 0 NMOS18 W={(0.2750)*1e-6} L=0.18u
X6 m1 0 0 0 NMOS18 W={(0.2750)*1e-6} L=0.18u
X7 out abar m2 0 NMOS18 W={(0.2750)*1e-6} L=0.18u
X8 m2 bbar 0 0 NMOS18 W={(0.2750)*1e-6} L=0.18u
X9 out abar k1 vdd PMOS18 W={(1.4003)*1e-6} L=0.18u
X10 k1 0 vdd vdd PMOS18 W={(1.4003)*1e-6} L=0.18u
X11 out in k2 vdd PMOS18 W={(1.4003)*1e-6} L=0.18u
X12 k2 bbar vdd vdd PMOS18 W={(1.4003)*1e-6} L=0.18u
.control
foreach cs 0 1 2 3 4
 foreach vd 1.620 1.800 1.980
  foreach tp -55 27 150
   alterparam case=$cs
   alterparam VDD=$vd
   reset
   option temp=$tp
   let half=$vd/2
   dc Vin 0 $vd 0.00360
   meas dc vm find v(in) when v(out)=$&half cross=1
   echo "RES cfg=b0 cs=$cs vd=$vd tp=$tp vm=$&vm"
  end
 end
end
.endc
.end
