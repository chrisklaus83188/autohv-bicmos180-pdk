.title cap_BUF_in
.include "C:/Users/chris/ngspice/Prompts/autohv_bicmos180_pdk/autohv_bicmos180_case.lib"
.param case=0
.param VDD=3.3
Vdd vdd 0 3.3
V_in in 0 0.0 AC 1
X1 mid in vdd vdd PMOS33 W={(2.1378)*1e-6} L=0.35u
X2 mid in 0 0 NMOS33 W={(0.6537)*1e-6} L=0.35u
X3 out mid vdd vdd PMOS33 W={(6.4134)*1e-6} L=0.35u
X4 out mid 0 0 NMOS33 W={(1.9612)*1e-6} L=0.35u
.control
foreach vb 0 3.3
  alter V_in dc=$vb
  ac lin 1 1e6 1e6
  let cpf = abs(imag(V_in#branch))/6283185.307*1e15
  echo "RES cap=$&cpf"
end
.endc
.end
