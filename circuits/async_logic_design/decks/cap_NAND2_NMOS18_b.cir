.title cap_NAND2_b
.include "../../../autohv_bicmos180_case.lib"
.param case=0
.param VDD=1.8
Vdd vdd 0 1.8
V_a a 0 0.9
V_b b 0 0.0 AC 1
X1 out a vdd vdd PMOS18 W={(2.4369)*1e-6} L=0.18u
X2 out b vdd vdd PMOS18 W={(2.4369)*1e-6} L=0.18u
X3 out a n1 0 NMOS18 W={(1.8682)*1e-6} L=0.18u
X4 n1 b 0 0 NMOS18 W={(1.8682)*1e-6} L=0.18u
.control
foreach vb 0 1.8
  alter V_b dc=$vb
  ac lin 1 1e6 1e6
  let cpf = abs(imag(V_b#branch))/6283185.307*1e15
  echo "RES cap=$&cpf"
end
.endc
.end
