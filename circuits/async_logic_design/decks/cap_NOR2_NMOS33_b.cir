.title cap_NOR2_b
.include "../../../autohv_bicmos180_case.lib"
.param case=0
.param VDD=3.3
Vdd vdd 0 3.3
V_a a 0 1.65
V_b b 0 0.0 AC 1
X1 p1 a vdd vdd PMOS33 W={(3.5886)*1e-6} L=0.35u
X2 out b p1 vdd PMOS33 W={(3.5886)*1e-6} L=0.35u
X3 out a 0 0 NMOS33 W={(0.3000)*1e-6} L=0.35u
X4 out b 0 0 NMOS33 W={(0.3000)*1e-6} L=0.35u
.control
foreach vb 0 3.3
  alter V_b dc=$vb
  ac lin 1 1e6 1e6
  let cpf = abs(imag(V_b#branch))/6283185.307*1e15
  echo "RES cap=$&cpf"
end
.endc
.end
