.title cap_AND2_a
.include "../../../autohv_bicmos180_case.lib"
.param case=0
.param VDD=5.0
Vdd vdd 0 5.0
V_a a 0 0.0 AC 1
V_b b 0 2.5
X1 nd a vdd vdd PMOS50 W={(1.8756)*1e-6} L=0.5u
X2 nd b vdd vdd PMOS50 W={(1.8756)*1e-6} L=0.5u
X3 nd a n1 0 NMOS50 W={(2.2936)*1e-6} L=0.5u
X4 n1 b 0 0 NMOS50 W={(2.2936)*1e-6} L=0.5u
X5 out nd vdd vdd PMOS50 W={(3.0434)*1e-6} L=0.5u
X6 out nd 0 0 NMOS50 W={(1.1202)*1e-6} L=0.5u
.control
foreach vb 0 5.0
  alter V_a dc=$vb
  ac lin 1 1e6 1e6
  let cpf = abs(imag(V_a#branch))/6283185.307*1e15
  echo "RES cap=$&cpf"
end
.endc
.end
