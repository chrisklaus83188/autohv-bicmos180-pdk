.title ratio_INV
.include "../../../autohv_bicmos180_case.lib"
.param case=0
.param VDD=3.3
.param S=1.0
.param R=0.3
Vdd vdd 0 3.3
Vin in 0 1.65
X1 out in vdd vdd PMOS33 W={(S*R)*1e-6} L=0.35u
X2 out in 0 0 NMOS33 W={(S)*1e-6} L=0.35u
.control
let half = 1.65
foreach rr 0.3000 0.5000 0.8000 1.2000 1.8000 2.6000 3.6000 5.0000 7.0000 10.0000 14.0000 19.0000 25.0000 32.0000
  alterparam R=$rr
  reset
  dc Vin 0 3.3 0.00825
  meas dc vm find v(in) when v(out)=$&half cross=1
  echo "RES R=$rr vm=$&vm"
end
.endc
.end
