.title gp
.include "C:/Users/chris/ngspice/Prompts/autohv_bicmos180_pdk/autohv_bicmos180_case.lib"
.param case=0
.param VDD=1.8
Vdd vdd 0 1.8
Vd dd 0 0.9
Vg g 0 0.9 AC 1
X1 dd g vdd vdd PMOS18 W=10u L=0.18u
.control
ac lin 1 1e6 1e6
let gpm = abs(imag(Vg#branch))/(2*PI*1e6)/10*1e15
echo "RES gp=$&gpm"
.endc
.end
