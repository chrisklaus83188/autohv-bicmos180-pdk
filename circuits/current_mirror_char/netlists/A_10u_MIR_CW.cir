.title A_10u_MIR_CW
.include "/Users/christopherklaus/Documents/ngspice/autohv-bicmos180-pdk/autohv_bicmos180_case.lib"
.param case=0 PROC_ON=0 MM_ON=0 MM_SIGMA=0
.options temp=27
Vdd vdd 0 5
Iin ng 0 1e-05
Xin nA ng vdd vdd PMOS50 W=8.12278e-05 L=2e-06 M=1
Xincw ng ncw nA vdd PMOS50 W=8.12278e-05 L=2e-06 M=1
Vbcw vdd ncw 1.6
Xout nB ng vdd vdd PMOS50 W=8.12278e-05 L=2e-06 M=1
Xoutcw nout ncw nB vdd PMOS50 W=8.12278e-05 L=2e-06 M=1
Vout nout 0 0
.control
dc Vout 0 5 0.01
wrdata /Users/christopherklaus/Documents/ngspice/autohv-bicmos180-pdk/circuits/current_mirror_char/raw/ignore.dat i(Vout)
.endc
.end
