.title A_100u_MIR_S
.include "../../../autohv_bicmos180_case.lib"
.param case=0 PROC_ON=0 MM_ON=0 MM_SIGMA=0
.options temp=27
Vdd vdd 0 5
Iin nin 0 0.0001
Xin nin nin vdd vdd PMOS50 W=8.12278e-05 L=2e-06 M=1
Xout nout nin vdd vdd PMOS50 W=8.12278e-05 L=2e-06 M=1
Vout nout 0 0
.control
dc Vout 0 5 0.01
wrdata ignore.dat i(Vout)
.endc
.end
