.title mc_DLYR
.include "../../../autohv_bicmos180_case.lib"
.param case=0
.param PROC_ON=1
.param MM_ON=1
.option num_threads=2
Vdd vdd 0 3.3
Vin in 0 PULSE(0 3.3 20n 0.02n 0.02n 80n 400n)
XI1 nIN in vdd vdd PMOS33 W=0.95u L=0.35u
XI2 nIN in 0   0   NMOS33 W=0.4u L=0.35u
XR nIN nC RPOLY_HI L=55.9375u W=0.5u
XC nC 0 CMIM_HI L=5.3600u W=5.3600u
XBP nC in vdd vdd PMOS33 W=0.8u L=0.35u
XS1 s1 nC 0   0   NMOS33 W=0.4u L=0.35u
XS2 out nC s1 0 NMOS33 W=0.4u L=0.35u
XS3 s2 nC vdd vdd PMOS33 W=0.95u L=0.35u
XS4 out nC s2 vdd PMOS33 W=0.95u L=0.35u
XS5 vdd out s1 0   NMOS33 W=0.4u L=0.35u
XS6 0   out s2 vdd PMOS33 W=0.95u L=0.35u
CL out 0 5.0f
.control
let nmc = 200
let i = 0
dowhile i < nmc
  reset
  option temp=27
  let h=1.65
  let v10=0.33
  let v90=2.9699999999999998
  tran 0.05n 180n
  meas tran m  trig v(in) val=$&h rise=1 targ v(out) val=$&h rise=1
  meas tran fe trig v(in) val=$&h fall=1 targ v(out) val=$&h fall=1
  meas tran tr trig v(out) val=$&v10 rise=1 td=19n targ v(out) val=$&v90 rise=1 td=19n
  meas tran tf trig v(out) val=$&v90 fall=1 td=99n targ v(out) val=$&v10 fall=1 td=99n
  echo "RES it=$&i m=$&m fe=$&fe tr=$&tr tf=$&tf"
  let i = i + 1
end
.endc
.end
