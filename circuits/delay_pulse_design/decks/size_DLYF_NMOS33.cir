.title size_DLYF_NMOS33
.include "../../../autohv_bicmos180_case.lib"
.param case=0
Vdd vdd 0 3.3
Vin in 0 PULSE(0 3.3 20n 0.02n 0.02n 80n 200n)
XI1 nIN in vdd vdd PMOS33 W=0.95u L=0.35u
XI2 nIN in 0   0   NMOS33 W=0.4u L=0.35u
XR nIN nC RPOLY_HI L=55.9375u W=0.5u
XC nC 0 CMIM_HI L=5.3600u W=5.3600u
XBP nC in 0 0 NMOS33 W=0.8u L=0.35u
XS1 s1 nC 0   0   NMOS33 W=0.4u L=0.35u
XS2 out nC s1 0 NMOS33 W=0.4u L=0.35u
XS3 s2 nC vdd vdd PMOS33 W=0.95u L=0.35u
XS4 out nC s2 vdd PMOS33 W=0.95u L=0.35u
XS5 vdd out s1 0   NMOS33 W=0.4u L=0.35u
XS6 0   out s2 vdd PMOS33 W=0.95u L=0.35u
CL out 0 5.0f
.control
option temp=27
tran 0.02n 200n
meas tran tdr trig v(in) val=1.65 rise=1 targ v(out) val=1.65 rise=1
meas tran tdf trig v(in) val=1.65 fall=1 targ v(out) val=1.65 fall=1
echo "RES tdr=$&tdr tdf=$&tdf"
.endc
.end
