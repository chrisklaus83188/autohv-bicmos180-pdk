.title verify PLO_3V3
.include "../../../autohv_bicmos180_case.lib"
.include "../cells.lib"
.param case=0
Vd v 0 3.3
Vi i 0 PULSE(0 3.3 20n 0.02n 0.02n 80n 400n)
X1 i o v 0 PLO_3V3
CL o 0 5f
.control
option temp=27
tran 0.02n 220n
meas tran tmd trig v(o) val=1.65 fall=1 td=99n targ v(o) val=1.65 rise=1 td=99n
meas tran tmp find v(o) at=80n
meas tran hi find v(o) at=10n
meas tran lo find v(o) at=110n
echo "RES tmd=$&tmd tmp=$&tmp lo=$&lo hi=$&hi"
.endc
.end
