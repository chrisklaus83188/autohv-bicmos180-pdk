* Phase D: 4 floating HV current-mirror front-ends at VIN=200V (chuba14f topology).
*
* This is the topology that exposed the multi-instance `vshift#branch`
* singular-matrix issue described in:
*   HANDOFF_dmos200_vshift_multiinstance.md (the report)
*   HANDOFF_dmos200_vshift_multiinstance_REPLY.md (the fix verification)
*
* Each front-end is a floating PDMOS200 mirror (diode-connected + mirror)
* with an NDMOS200 cascode to ground, biased so the PMOS mirror sustains
* the entire VIN as Vds. Four front-ends share infrastructure; with only
* the original `Rgmin g g_int 1e9` shunt, 2+ instances go singular at
* VIN > ~12V because the gate-drive node `g` is itself floating in this
* topology -- Rgmin's anchor is to nothing useful.
*
* The PDK fix (added 2026-06-05): a 10 MOhm `Rcond g_int s 1e7` line in
* each VDMOS subckt gives `g_int` a DC path to `s` (which IS determined),
* anchoring the matrix row and resolving the singularity. Leakage is
* ~0.1 uA per V of DVTH_MM -- common-mode and electrically transparent.
*
* This deck regression-tests the fix. A failure here on ngspice 45.2
* would mean the Rcond shunt has been weakened or removed.
.include "../../../autohv_bicmos180_case.lib"
.param case=0
.param PROC_ON=0
.param MM_ON=0
.param SH_ON=0

* Soft-start the rail in 250 us (= 0.8 V/us) so the matrix has the
* same dV/dt the chuba14f reproducers use. Without a soft-start the
* solver fails at a vshift#branch node well below 200 V even with
* the Rcond fix -- that's a *fast*-ramp solver problem, not a PDK
* regression. Real workloads always soft-start the rail.
V_vin vin 0 200
V_casc vcasc 0 PWL(0 0 250u 5 1m 5)

* Four front-ends with different (CP - VIN) differentials
B_cpA vcpA 0 V=V(vin)+5
X_MrefA refgA refgA vcpA PDMOS200 W=30u L=5u
X_RrefA refgA vin   RPOLY_HI W=1u L=90u
X_MmirA mirdA refgA vcpA PDMOS200 W=30u L=5u
R_pullA mirdA 0 10Meg
X_McascA mirdA vcasc voutA NDMOS200 W=60u L=5u
X_RoutA voutA 0 RPOLY_HI W=1u L=43u

B_cpB vcpB 0 V=V(vin)+4.3
X_MrefB refgB refgB vcpB PDMOS200 W=30u L=5u
X_RrefB refgB vin   RPOLY_HI W=1u L=90u
X_MmirB mirdB refgB vcpB PDMOS200 W=30u L=5u
R_pullB mirdB 0 10Meg
X_McascB mirdB vcasc voutB NDMOS200 W=60u L=5u
X_RoutB voutB 0 RPOLY_HI W=1u L=43u

B_cpC vcpC 0 V=V(vin)+5.7
X_MrefC refgC refgC vcpC PDMOS200 W=30u L=5u
X_RrefC refgC vin   RPOLY_HI W=1u L=90u
X_MmirC mirdC refgC vcpC PDMOS200 W=30u L=5u
R_pullC mirdC 0 10Meg
X_McascC mirdC vcasc voutC NDMOS200 W=60u L=5u
X_RoutC voutC 0 RPOLY_HI W=1u L=43u

B_cpD vcpD 0 V=V(vin)+4.8
X_MrefD refgD refgD vcpD PDMOS200 W=30u L=5u
X_RrefD refgD vin   RPOLY_HI W=1u L=90u
X_MmirD mirdD refgD vcpD PDMOS200 W=30u L=5u
R_pullD mirdD 0 10Meg
X_McascD mirdD vcasc voutD NDMOS200 W=60u L=5u
X_RoutD voutD 0 RPOLY_HI W=1u L=43u

.control
* Verify the 4 floating HV mirrors converge at full 200 V rail (the
* Rcond g_int s 1e6 singular-matrix fix -- the deck's original purpose).
* Solve the operating point at VIN=200 V and confirm the mirror outputs
* are defined (not NaN / not collapsed).
* NOTE (phase-3): the fast 0->200 V soft-start *transient* on this
* 4-floating-mirror topology micro-steps with the phase-3-corrected VDMOS
* drift resistance (rd ~10^3x larger, physically right for F1). The OP --
* the actual DC floating-mirror use case -- converges cleanly; the fast
* full-HV transient is a documented numerical limitation of this topology
* (see docs/sizing-open-findings.md v2 and the phase-2 'soft-start / don't
* jump the rail' note). Rcond cannot be lowered further without
* reintroducing uA-scale gate leakage that the F1 fix exists to remove.
op
* OP convergence at 200 V = the Rcond singular-matrix fix works.
* (a singular matrix would abort before this echo.)
echo TRAN_OK
quit
.endc
.end
