* Phase D: NDMOS200 terminal Coss sanity check (HANDOFF_vdmos_caps.md).
*
* Catches re-introduction of the ~1000x VDMOS cap unit slip that was fixed
* on 2026-06-01. AC analysis at 1 MHz with Vds=0.1V on a 40um x 8um NDMOS200,
* gate held off. Drain terminal capacitance is computed from displacement
* current: Cdrain = |i(VB)| / (2 pi f Vac).
*
* Baseline post-fix: ~105 fF (= 1.05e-13 F).
* Pre-fix bug:       ~105 pF (= 1.05e-10 F).
* Threshold: 1 pF (1e-12 F) gives ~10x margin over post-fix; catches any
* 10x-or-worse regression.
.include "../../../autohv_bicmos180_case.lib"
.param case=0
.param PROC_ON=0
.param MM_ON=0
.param SH_ON=0

VB d 0 DC 0.1 AC 1
Vg g 0 DC 0
XN5 d g 0 NDMOS200 W=40u L=8u

.ac lin 1 1meg 1meg
.control
run
let cdrain = abs(i(VB))/(2*PI*1e6)
print cdrain
if cdrain < 1e-12
  echo TRAN_OK
else
  echo COSS_TOO_LARGE_FAIL
end
quit
.endc
.end
