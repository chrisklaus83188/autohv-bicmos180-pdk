* Phase D: AC current through RNWELL with V(p,n) crossing zero each
* half-cycle.
*
* This is the canonical "abs() kink killer". The pre-fix VCR expression
*   BVCR ... V={ V(p,mid)*(VCR1*abs(V(p,n)) + VCR2*V(p,n)*V(p,n)) }
* has a discontinuous derivative at V=0; on a sinusoidal drive that
* lands on V=0 each half-cycle the Newton/LTE loop never stabilizes
* its timestep -- the pre-fix lib hung at >120 s on this kind of
* circuit. The post-fix smoothed form
*   sqrt(V(p,n)*V(p,n)+1e-6)
* is C-infinity at V=0 and completes in a few seconds.
*
* RNWELL is the worst-case device (highest VCR1 = 8000 ppm/V).
.include "../../../autohv_bicmos180_case.lib"
.param case=0
.param PROC_ON=0
.param MM_ON=0

Vs s 0 SIN(0 5 1MEG)
XR s 0 RNWELL L=100u W=10u

.control
tran 10n 5u
echo TRAN_OK
quit
.endc
.end
