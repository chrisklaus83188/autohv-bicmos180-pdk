* Phase D: DIO_PN half-wave rectifier with RC load
* Stress: junction-cap charge through the diode, reverse-recovery via
* the model tt, repeated 0-crossings of the source sinewave.
.include "../../../autohv_bicmos180_case.lib"
.param case=0
.param PROC_ON=0
.param MM_ON=0

Vs    s 0 SIN(0 5 1MEG)
XD    s out DIO_PN AREA=1
Rload out 0 1k
Cload out 0 1n

.control
tran 10n 5u
echo TRAN_OK
quit
.endc
.end
