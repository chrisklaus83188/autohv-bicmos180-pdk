* Phase D: NPN_LV common-emitter pulse response
* Stress: low-bias Gummel-Poon turn-on, Miller-effect collector loading,
* avalanche subckt branch in the off-region (kept biased far from BVCBO).
.include "../../../autohv_bicmos180_case.lib"
.param case=0
.param PROC_ON=0
.param MM_ON=0

Vcc  vcc 0 5
Rc   vcc c 1k
Rb   b   bi 10k
Vb   b   0 PULSE(0 1 5n 1n 1n 100n 200n)
XQ   c bi 0 NPN_LV AREA=1

.control
tran 1n 250n
echo TRAN_OK
quit
.endc
.end
