* NDMOS200 [asis] Vov=4 V: Vgs=+5.25 V, Vds=+10 V
* Generated by pdk_validation/characterization -- phase 2 harness.
* Instruments (ideal, not DUT): Vd, Vg -- ideal sources
* Re-run standalone:  ngspice -b <this file>
.include "C:/Users/chris/ngspice/BiCMOS Process - Automotive/autohv-bicmos180-pdk/autohv_bicmos180_case.lib"
.include "C:/Users/chris/ngspice/BiCMOS Process - Automotive/autohv-bicmos180-pdk/pdk_validation/characterization/results/local_models/NDMOS200_asis.mod"
.param case=0
.param PROC_ON=0
.param MM_ON=0
M0 d g 0 NDMOS200_ASIS m=1
Vd d 0 dc 10.0
Vg g 0 dc 5.25
.control
set width=1000
op
print @m0[id]
print i(Vd)
.endc
.end
