* RPPLUS R(V) sweep -5..+5 V, L=100.0u W=10.0u
* Generated by pdk_validation/characterization -- phase 2 harness.
* Instruments (ideal, not DUT): Vp -- ideal DC source (swept)
* Re-run standalone:  ngspice -b <this file>
.include "C:/Users/chris/ngspice/BiCMOS Process - Automotive/autohv-bicmos180-pdk/autohv_bicmos180_case.lib"
.param case=0
.param PROC_ON=0
.param MM_ON=0
Vp p 0 dc 1
X1 p 0 RPPLUS L=100.0u W=10.0u
.control
set width=1000
set numdgt=12
dc Vp -5 5 0.25
let iload = -i(Vp)
echo TBL_BEGIN
print iload
echo TBL_END
.endc
.end
