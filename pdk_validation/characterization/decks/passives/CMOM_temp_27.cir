* CMOM C(V) by AC probe at 1e+06 Hz, L=100.0u W=100.0u, corner TT, T=27.0 degC
* Generated by pdk_validation/characterization -- phase 2 harness.
* Instruments (ideal, not DUT): Vb<k> -- ideal DC bias + 1 V AC probe, one per bias
* Re-run standalone:  ngspice -b <this file>
.include "C:/Users/chris/ngspice/BiCMOS Process - Automotive/autohv-bicmos180-pdk/autohv_bicmos180_case.lib"
.param case=0
.param PROC_ON=0
.param MM_ON=0
.options temp=27.0
Vb0 p0 0 dc 0.0 ac 1
X0 p0 0 CMOM L=100.0u W=100.0u
Vb1 p1 0 dc 0.5 ac 1
X1 p1 0 CMOM L=100.0u W=100.0u
Vb2 p2 0 dc 1.0 ac 1
X2 p2 0 CMOM L=100.0u W=100.0u
Vb3 p3 0 dc 1.5 ac 1
X3 p3 0 CMOM L=100.0u W=100.0u
Vb4 p4 0 dc 2.0 ac 1
X4 p4 0 CMOM L=100.0u W=100.0u
Vb5 p5 0 dc 3.0 ac 1
X5 p5 0 CMOM L=100.0u W=100.0u
Vb6 p6 0 dc 4.0 ac 1
X6 p6 0 CMOM L=100.0u W=100.0u
Vb7 p7 0 dc 5.0 ac 1
X7 p7 0 CMOM L=100.0u W=100.0u
.control
set width=1000
set numdgt=12
ac lin 1 1e+06 1e+06
print imag(i(Vb0))
print imag(i(Vb1))
print imag(i(Vb2))
print imag(i(Vb3))
print imag(i(Vb4))
print imag(i(Vb5))
print imag(i(Vb6))
print imag(i(Vb7))
.endc
.end
