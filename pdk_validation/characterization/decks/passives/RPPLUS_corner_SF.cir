* RPPLUS R at Vp=0.1 V, L=100.0u W=10.0u, corner SF
* Generated by pdk_validation/characterization -- phase 2 harness.
* Instruments (ideal, not DUT): Vp -- ideal DC source (forcing terminal bias)
* Re-run standalone:  ngspice -b <this file>
.include "C:/Users/chris/ngspice/BiCMOS Process - Automotive/autohv-bicmos180-pdk/autohv_bicmos180_case.lib"
.param case=4
.param PROC_ON=0
.param MM_ON=0
Vp p 0 dc 0.1
X1 p 0 RPPLUS L=100.0u W=10.0u
.control
set width=1000
set numdgt=12
op
print i(Vp)
.endc
.end
