* PDMOS200 model-card readback (TT, 27 degC) -- stock
* Generated by pdk_validation/characterization -- phase 2 harness.
* Instruments (ideal, not DUT): Vd, Vg -- ideal sources at 0 V for a trivial op
* Re-run standalone:  ngspice -b <this file>
.include "C:/Users/chris/ngspice/BiCMOS Process - Automotive/autohv-bicmos180-pdk/autohv_bicmos180_case.lib"
.param case=0
.param PROC_ON=0
.param MM_ON=0
XH1 d g 0 PDMOS200 W=10u L=8u
Vd d 0 dc 0
Vg g 0 dc 0
.control
set width=1000
op
print @PDMOS200_INT[vto] @PDMOS200_INT[kp] @PDMOS200_INT[theta] @PDMOS200_INT[lambda] @PDMOS200_INT[rd] @PDMOS200_INT[rs] @PDMOS200_INT[ksubthres] @PDMOS200_INT[mtriode] @PDMOS200_INT[bv]
.endc
.end
