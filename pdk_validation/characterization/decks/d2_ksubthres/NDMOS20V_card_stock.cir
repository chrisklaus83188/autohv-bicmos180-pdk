* NDMOS20V model-card readback (TT, 27 degC) -- stock
* Generated by pdk_validation/characterization -- phase 2 harness.
* Instruments (ideal, not DUT): Vd, Vg -- ideal sources at 0 V for a trivial op
* Re-run standalone:  ngspice -b <this file>
.include "C:/Users/chris/ngspice/BiCMOS Process - Automotive/autohv-bicmos180-pdk/autohv_bicmos180_case.lib"
.param case=0
.param PROC_ON=0
.param MM_ON=0
XH1 d g 0 NDMOS20V W=10u
Vd d 0 dc 0
Vg g 0 dc 0
.control
set width=1000
op
print @NDMOS20V_INT[vto] @NDMOS20V_INT[kp] @NDMOS20V_INT[theta] @NDMOS20V_INT[lambda] @NDMOS20V_INT[rd] @NDMOS20V_INT[rs] @NDMOS20V_INT[ksubthres] @NDMOS20V_INT[mtriode] @NDMOS20V_INT[bv]
.endc
.end
