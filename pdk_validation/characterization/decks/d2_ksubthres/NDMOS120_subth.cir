* NDMOS120 [stock] subthreshold Id-Vg: Vds=+0.1 V
* Generated by pdk_validation/characterization -- phase 2 harness.
* Instruments (ideal, not DUT): Vd (drain bias), Vg (gate sweep) -- ideal sources
* Re-run standalone:  ngspice -b <this file>
.include "C:/Users/chris/ngspice/BiCMOS Process - Automotive/autohv-bicmos180-pdk/autohv_bicmos180_case.lib"
.param case=0
.param PROC_ON=0
.param MM_ON=0
XH1 d g 0 NDMOS120 W=10u
Vd d 0 dc 0.1
Vg g 0 dc 0
.control
set width=1000
dc Vg 0.0 1.4 0.004
echo TBL_BEGIN
print abs(i(Vd))
echo TBL_END
.endc
.end
