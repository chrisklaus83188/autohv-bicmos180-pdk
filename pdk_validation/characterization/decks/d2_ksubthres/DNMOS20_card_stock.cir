* DNMOS20 model-card readback (TT, 27 degC) -- stock
* Generated by pdk_validation/characterization -- phase 2 harness.
* Instruments (ideal, not DUT): Vd, Vg -- ideal sources at 0 V for a trivial op
* Re-run standalone:  ngspice -b <this file>
.include "C:/Users/chris/ngspice/BiCMOS Process - Automotive/autohv-bicmos180-pdk/autohv_bicmos180_case.lib"
.param case=0
.param PROC_ON=0
.param MM_ON=0
XH1 d g 0 DNMOS20 W=10u
Vd d 0 dc 0
Vg g 0 dc 0
.control
set width=1000
op
print @DNMOS20_INT[vto] @DNMOS20_INT[kp] @DNMOS20_INT[theta] @DNMOS20_INT[lambda] @DNMOS20_INT[rd] @DNMOS20_INT[rs] @DNMOS20_INT[ksubthres] @DNMOS20_INT[mtriode] @DNMOS20_INT[bv]
.endc
.end
