* NDMOS80 model-card readback (TT, 27 degC) -- stock
* Generated by pdk_validation/characterization -- phase 2 harness.
* Instruments (ideal, not DUT): Vd, Vg -- ideal sources at 0 V for a trivial op
* Re-run standalone:  ngspice -b <this file>
.include "C:/Users/chris/ngspice/BiCMOS Process - Automotive/autohv-bicmos180-pdk/autohv_bicmos180_case.lib"
.param case=0
.param PROC_ON=0
.param MM_ON=0
XH1 d g 0 NDMOS80 W=10u
Vd d 0 dc 0
Vg g 0 dc 0
.control
set width=1000
op
print @NDMOS80_INT[vto] @NDMOS80_INT[kp] @NDMOS80_INT[theta] @NDMOS80_INT[lambda] @NDMOS80_INT[rd] @NDMOS80_INT[rs] @NDMOS80_INT[ksubthres] @NDMOS80_INT[mtriode] @NDMOS80_INT[bv]
.endc
.end
