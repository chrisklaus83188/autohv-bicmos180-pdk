* NDMOS20 model-card readback (TT, 27 degC) -- stock
* Generated by pdk_validation/characterization -- phase 2 harness.
* Instruments (ideal, not DUT): Vd, Vg -- ideal sources at 0 V for a trivial op
* Re-run standalone:  ngspice -b <this file>
.include "C:/Users/chris/ngspice/BiCMOS Process - Automotive/autohv-bicmos180-pdk/autohv_bicmos180_case.lib"
.param case=0
.param PROC_ON=0
.param MM_ON=0
XH1 d g 0 NDMOS20 W=10u
Vd d 0 dc 0
Vg g 0 dc 0
.control
set width=1000
op
print @NDMOS20_INT[vto] @NDMOS20_INT[kp] @NDMOS20_INT[theta] @NDMOS20_INT[lambda] @NDMOS20_INT[rd] @NDMOS20_INT[rs] @NDMOS20_INT[ksubthres] @NDMOS20_INT[mtriode] @NDMOS20_INT[bv]
.endc
.end
