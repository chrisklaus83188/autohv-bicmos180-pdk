* NDMOS60 model-card readback (TT, 27 degC) -- stock
* Generated by pdk_validation/characterization -- phase 2 harness.
* Instruments (ideal, not DUT): Vd, Vg -- ideal sources at 0 V for a trivial op
* Re-run standalone:  ngspice -b <this file>
.include "C:/Users/chris/ngspice/BiCMOS Process - Automotive/autohv-bicmos180-pdk/autohv_bicmos180_case.lib"
.param case=0
.param PROC_ON=0
.param MM_ON=0
XH1 d g 0 NDMOS60 W=10u
Vd d 0 dc 0
Vg g 0 dc 0
.control
set width=1000
op
print @NDMOS60_INT[vto] @NDMOS60_INT[kp] @NDMOS60_INT[theta] @NDMOS60_INT[lambda] @NDMOS60_INT[rd] @NDMOS60_INT[rs] @NDMOS60_INT[ksubthres] @NDMOS60_INT[mtriode] @NDMOS60_INT[bv]
.endc
.end
