* PMOS12 Idsat at Vgs=Vds=12.0 V, W=10u L=0.15u
* Generated by pdk_validation/characterization -- phase 2 harness.
* Instruments (ideal, not DUT): Vd, Vg -- ideal sources
* Re-run standalone:  ngspice -b <this file>
.include "C:/Users/chris/ngspice/BiCMOS Process - Automotive/autohv-bicmos180-pdk/autohv_bicmos180_case.lib"
.param case=0
.param PROC_ON=0
.param MM_ON=0
XM1 d g 0 0 PMOS12 W=10u L=0.15u
XM3 d3 g 0 0 PMOS12 W=10u L=1u
Vd3 d3 0 dc -12.0
Vd d 0 dc -12.0
Vg g 0 dc -12.0
.control
op
print @m.xm1.m0[id] @m.xm3.m0[id]
.endc
.end
