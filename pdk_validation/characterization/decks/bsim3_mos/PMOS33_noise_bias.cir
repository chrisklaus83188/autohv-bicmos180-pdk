* PMOS33 noise bias search: Id-Vg at Vds=1.65 V
* Generated by pdk_validation/characterization -- phase 2 harness.
* Instruments (ideal, not DUT): Vd, Vg -- ideal sources
* Re-run standalone:  ngspice -b <this file>
.include "C:/Users/chris/ngspice/BiCMOS Process - Automotive/autohv-bicmos180-pdk/autohv_bicmos180_case.lib"
.param case=0
.param PROC_ON=0
.param MM_ON=0
XM1 d g 0 0 PMOS33 W=10u L=0.35u
Vd d 0 dc -1.65
Vg g 0 dc 0
.control
dc Vg 0 -3.3 -0.005
echo TBL_BEGIN
print abs(i(Vd))
echo TBL_END
.endc
.end
