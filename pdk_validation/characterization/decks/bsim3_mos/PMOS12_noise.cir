* PMOS12 flicker corner, W=10u L=0.15u, Vds=6.0 V
* Generated by pdk_validation/characterization -- phase 2 harness.
* Instruments (ideal, not DUT): Vdd via 1e9 H bias choke (noiseless); Vg -- ideal
* Re-run standalone:  ngspice -b <this file>
.include "C:/Users/chris/ngspice/BiCMOS Process - Automotive/autohv-bicmos180-pdk/autohv_bicmos180_case.lib"
.param case=0
.param PROC_ON=0
.param MM_ON=0
XM1 d g 0 0 PMOS12 W=10u L=0.15u
Vdd dd 0 dc -6.0
Lb dd d 1e9
Vg g 0 dc -1.23 ac 1
.control
op
print @m.xm1.m0[id] @m.xm1.m0[gm]
noise v(d) Vg dec 10 1 1e9
setplot noise1
echo TBL_BEGIN
print inoise_spectrum
echo TBL_END
.endc
.end
