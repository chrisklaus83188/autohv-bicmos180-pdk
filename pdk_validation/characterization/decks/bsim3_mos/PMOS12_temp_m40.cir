* PMOS12 corner TT at -40.0 degC
* Generated by pdk_validation/characterization -- phase 2 harness.
* Instruments (ideal, not DUT): Vdi, Vdt, Vg -- ideal sources
* Re-run standalone:  ngspice -b <this file>
.include "C:/Users/chris/ngspice/BiCMOS Process - Automotive/autohv-bicmos180-pdk/autohv_bicmos180_case.lib"
.param case=0
.param PROC_ON=0
.param MM_ON=0
.options temp=-40.0
XI di g 0 0 PMOS12 W=10u L=0.15u
XT dt g 0 0 PMOS12 W=10u L=0.15u
Vdi di 0 dc -12.0
Vdt dt 0 dc -0.1
Vg g 0 dc -12.0
.control
op
print @m.xi.m0[id] @m.xt.m0[vth]
.endc
.end
