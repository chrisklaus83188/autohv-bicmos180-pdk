* PMOS12 Id-Vg, linear region (Vds=0.1 V), W=10u L=0.15u
* Generated by pdk_validation/characterization -- phase 2 harness.
* Instruments (ideal, not DUT): Vd (drain bias), Vg (gate sweep) -- ideal sources
* Re-run standalone:  ngspice -b <this file>
.include "C:/Users/chris/ngspice/BiCMOS Process - Automotive/autohv-bicmos180-pdk/autohv_bicmos180_case.lib"
.param case=0
.param PROC_ON=0
.param MM_ON=0
XM1 d g 0 0 PMOS12 W=10u L=0.15u
Vd d 0 dc -0.1
Vg g 0 dc -12.0
.control
op
print @m.xm1.m0[vth] @m.xm1.m0[id] @m.xm1.m0[gm]
dc Vg 0 -12.0 -0.005
echo TBL_BEGIN
print abs(i(Vd))
echo TBL_END
.endc
.end
