* NMOS50 AC capacitance extraction at 1e+06 Hz
* Generated by pdk_validation/characterization -- phase 2 harness.
* Instruments (ideal, not DUT): Vg1/Vd3 AC probes (1 V), all other sources ideal DC
* Re-run standalone:  ngspice -b <this file>
.include "C:/Users/chris/ngspice/BiCMOS Process - Automotive/autohv-bicmos180-pdk/autohv_bicmos180_case.lib"
.param case=0
.param PROC_ON=0
.param MM_ON=0
XC1 d1 g1 0 0 NMOS50 W=10u L=10u
Vd1 d1 0 dc 0
Vg1 g1 0 dc 5.0 ac 1
XC2 d2 g2 0 0 NMOS50 W=10u L=0.5u
Vd2 d2 0 dc 0
Vg2 g2 0 dc 0 ac 1
XC3 d3 0 0 b3 NMOS50 W=10u L=0.5u
Vd3 d3 0 dc 0 ac 1
Vb3 b3 0 dc 0
.control
ac lin 1 1e+06 1e+06
print imag(i(Vg1)) imag(i(Vd2)) imag(i(Vb3))
.endc
.end
