* Monte Carlo matched pairs, all 9 passives, W=L=10.0u (W*L=100 um^2), MM_ON=1 PROC_ON=0
* Generated by pdk_validation/characterization -- phase 2 harness.
* Instruments (ideal, not DUT): Vr*/Vc* -- ideal 1 V AC probes at DC 0
* Re-run standalone:  ngspice -b <this file>
.include "C:/Users/chris/ngspice/BiCMOS Process - Automotive/autohv-bicmos180-pdk/autohv_bicmos180_case.lib"
.param case=0
.param PROC_ON=0
.param MM_ON=1
VRPOLY_HIa nRPOLY_HIa 0 dc 0 ac 1
XRPOLY_HIa nRPOLY_HIa 0 RPOLY_HI L=10.0u W=10.0u
VRPOLY_HIb nRPOLY_HIb 0 dc 0 ac 1
XRPOLY_HIb nRPOLY_HIb 0 RPOLY_HI L=10.0u W=10.0u
VRPOLY_LOa nRPOLY_LOa 0 dc 0 ac 1
XRPOLY_LOa nRPOLY_LOa 0 RPOLY_LO L=10.0u W=10.0u
VRPOLY_LOb nRPOLY_LOb 0 dc 0 ac 1
XRPOLY_LOb nRPOLY_LOb 0 RPOLY_LO L=10.0u W=10.0u
VRNWELLa nRNWELLa 0 dc 0 ac 1
XRNWELLa nRNWELLa 0 RNWELL L=10.0u W=10.0u
VRNWELLb nRNWELLb 0 dc 0 ac 1
XRNWELLb nRNWELLb 0 RNWELL L=10.0u W=10.0u
VRNPLUSa nRNPLUSa 0 dc 0 ac 1
XRNPLUSa nRNPLUSa 0 RNPLUS L=10.0u W=10.0u
VRNPLUSb nRNPLUSb 0 dc 0 ac 1
XRNPLUSb nRNPLUSb 0 RNPLUS L=10.0u W=10.0u
VRPPLUSa nRPPLUSa 0 dc 0 ac 1
XRPPLUSa nRPPLUSa 0 RPPLUS L=10.0u W=10.0u
VRPPLUSb nRPPLUSb 0 dc 0 ac 1
XRPPLUSb nRPPLUSb 0 RPPLUS L=10.0u W=10.0u
VCMIM_STDa nCMIM_STDa 0 dc 0 ac 1
XCMIM_STDa nCMIM_STDa 0 CMIM_STD L=10.0u W=10.0u
VCMIM_STDb nCMIM_STDb 0 dc 0 ac 1
XCMIM_STDb nCMIM_STDb 0 CMIM_STD L=10.0u W=10.0u
VCMIM_HIa nCMIM_HIa 0 dc 0 ac 1
XCMIM_HIa nCMIM_HIa 0 CMIM_HI L=10.0u W=10.0u
VCMIM_HIb nCMIM_HIb 0 dc 0 ac 1
XCMIM_HIb nCMIM_HIb 0 CMIM_HI L=10.0u W=10.0u
VCMOMa nCMOMa 0 dc 0 ac 1
XCMOMa nCMOMa 0 CMOM L=10.0u W=10.0u
VCMOMb nCMOMb 0 dc 0 ac 1
XCMOMb nCMOMb 0 CMOM L=10.0u W=10.0u
VCFRINGEa nCFRINGEa 0 dc 0 ac 1
XCFRINGEa nCFRINGEa 0 CFRINGE L=10.0u W=10.0u
VCFRINGEb nCFRINGEb 0 dc 0 ac 1
XCFRINGEb nCFRINGEb 0 CFRINGE L=10.0u W=10.0u
.control
set width=1000
set numdgt=12
ac lin 1 1e+06 1e+06
print real(i(VRPOLY_HIa)) real(i(VRPOLY_HIb))
print real(i(VRPOLY_LOa)) real(i(VRPOLY_LOb))
print real(i(VRNWELLa)) real(i(VRNWELLb))
print real(i(VRNPLUSa)) real(i(VRNPLUSb))
print real(i(VRPPLUSa)) real(i(VRPPLUSb))
print imag(i(VCMIM_STDa)) imag(i(VCMIM_STDb))
print imag(i(VCMIM_HIa)) imag(i(VCMIM_HIb))
print imag(i(VCMOMa)) imag(i(VCMOMb))
print imag(i(VCFRINGEa)) imag(i(VCFRINGEb))
.endc
.end
