* sizing NMOS12 W=63.245553203367585 I=1e-05
* Generated by pdk_validation/characterization -- phase 2 harness.
* Instruments (ideal, not DUT): Ib ideal current bias
* Re-run standalone:  ngspice -b <this file>
.include "C:/Users/chris/ngspice/BiCMOS Process - Automotive/autohv-bicmos180-pdk/autohv_bicmos180_case.lib"
.param case=0
.param PROC_ON=0
.param MM_ON=0
Ib 0 dg 1e-05
X1 dg dg 0 0 NMOS12 W=63.2456u L=1u
.control
set noaskquit
op
print v(dg)
print @m.x1.m0[gm]
.endc
.end
