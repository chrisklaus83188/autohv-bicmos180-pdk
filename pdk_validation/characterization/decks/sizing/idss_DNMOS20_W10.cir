* idss DNMOS20 W=10.0
* Generated by pdk_validation/characterization -- phase 2 harness.
* Instruments (ideal, not DUT): Vd drain, Vg=0
* Re-run standalone:  ngspice -b <this file>
.include "C:/Users/chris/ngspice/BiCMOS Process - Automotive/autohv-bicmos180-pdk/autohv_bicmos180_case.lib"
.param case=0
.param PROC_ON=0
.param MM_ON=0
Vd d 0 10.0
Vg g 0 0
Vs s 0 0
X1 d g s DNMOS20 W=10u
.control
set noaskquit
op
print abs(i(Vd))
.endc
.end
