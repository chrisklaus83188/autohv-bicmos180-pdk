* NDMOS200 model-card readback (TT, 27 degC) -- d1
* Generated by pdk_validation/characterization -- phase 2 harness.
* Instruments (ideal, not DUT): Vd, Vg -- ideal sources at 0 V for a trivial op
* Re-run standalone:  ngspice -b <this file>
.include "C:/Users/chris/ngspice/BiCMOS Process - Automotive/autohv-bicmos180-pdk/autohv_bicmos180_case.lib"
.include "C:/Users/chris/ngspice/BiCMOS Process - Automotive/autohv-bicmos180-pdk/pdk_validation/characterization/results/local_models/NDMOS200_d1.mod"
.param case=0
.param PROC_ON=0
.param MM_ON=0
M0 d g 0 NDMOS200_D1 m=1
Vd d 0 dc 0
Vg g 0 dc 0
.control
set width=1000
op
print @NDMOS200_D1[vto] @NDMOS200_D1[kp] @NDMOS200_D1[theta] @NDMOS200_D1[lambda] @NDMOS200_D1[rd] @NDMOS200_D1[rs] @NDMOS200_D1[ksubthres] @NDMOS200_D1[mtriode] @NDMOS200_D1[bv]
.endc
.end
