* PNP_HV BVCEO, base open (1 Gohm to emitter), AREA=1
* Generated by pdk_validation/characterization -- phase 2 harness.
* Instruments (ideal, not DUT): Vcc sweep through a 100 kohm ballast, Vc 0 V ammeter, Rbopen 1 Gohm
* Re-run standalone:  ngspice -b <this file>
.include "C:/Users/chris/ngspice/BiCMOS Process - Automotive/autohv-bicmos180-pdk/autohv_bicmos180_case.lib"
.param case=0
.param PROC_ON=0
.param MM_ON=0
XQ c b 0 PNP_HV AREA=1
Rbopen b 0 1e9
Rball s cx 100000.0
Vc cx c dc 0
Vcc s 0 dc 0
.control
set width=1000
dc Vcc 0 -36.0 -0.02
echo TBL_BEGIN
print abs(v(c)) abs(i(Vc))
echo TBL_END
.endc
.end
