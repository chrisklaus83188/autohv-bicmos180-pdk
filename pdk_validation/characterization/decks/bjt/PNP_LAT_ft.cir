* PNP_LAT h21 vs frequency at 4 collector-current biases, Vce=2 V, AREA=1
* Generated by pdk_validation/characterization -- phase 2 harness.
* Instruments (ideal, not DUT): I1..I4 ideal base current sources (dc bias + 1 A ac), Vcc ideal 2 V rail, V1..V4 0 V ammeters
* Re-run standalone:  ngspice -b <this file>
.include "C:/Users/chris/ngspice/BiCMOS Process - Automotive/autohv-bicmos180-pdk/autohv_bicmos180_case.lib"
.param case=0
.param PROC_ON=0
.param MM_ON=0
Vcc dd 0 dc -2.0
XQ1 c1 b1 0 PNP_LAT AREA=1
V1 dd c1 dc 0
I1 b1 0 dc 3.4848301548499247e-07 ac 1
XQ2 c2 b2 0 PNP_LAT AREA=1
V2 dd c2 dc 0
I2 b2 0 dc 3.1990207365245095e-06 ac 1
XQ3 c3 b3 0 PNP_LAT AREA=1
V3 dd c3 dc 0
I3 b3 0 dc 3.162005054229267e-05 ac 1
XQ4 c4 b4 0 PNP_LAT AREA=1
V4 dd c4 dc 0
I4 b4 0 dc 0.0003842785028305162 ac 1
.control
set width=1000
ac dec 20 1e6 1e11
echo TBL_BEGIN
print mag(i(V1)) mag(i(V2)) mag(i(V3)) mag(i(V4))
echo TBL_END
.endc
.end
