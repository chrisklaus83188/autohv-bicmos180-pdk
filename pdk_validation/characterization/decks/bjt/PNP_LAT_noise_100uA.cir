* PNP_LAT base noise at Ib=3.19902e-06 A, Rc=10000 ohm, Rsrc=8.08526e+06 ohm, AREA=1
* Generated by pdk_validation/characterization -- phase 2 harness.
* Instruments (ideal, not DUT): Vb ideal source behind Rsrc = 1000*rpi (a synthesized current drive and the .noise input reference), Vdd ideal rail, Rc collector load
* Re-run standalone:  ngspice -b <this file>
.include "C:/Users/chris/ngspice/BiCMOS Process - Automotive/autohv-bicmos180-pdk/autohv_bicmos180_case.lib"
.param case=0
.param PROC_ON=0
.param MM_ON=0
XQ c b 0 PNP_LAT AREA=1
Vb bx 0 dc -26.54038979974494 ac 1
Rsrc bx b 8085263.559256889
Vdd dd 0 dc -3.0
Rc dd c 10000.0
.control
set width=1000
op
print v(c) v(b)
noise v(c) Vb dec 10 1 1e9
setplot noise1
echo TBL_BEGIN
print inoise_spectrum
echo TBL_END
.endc
.end
