* NPN_HV Gummel plot, Vcb=0 and Vce=2 V, AREA=1, corner SF
* Generated by pdk_validation/characterization -- phase 2 harness.
* Instruments (ideal, not DUT): Vb (base sweep), Ecb/Eb2 unity VCVS replicas, Vc1/Vc2/Vb2 0 V ammeters -- all ideal
* Re-run standalone:  ngspice -b <this file>
.include "C:/Users/chris/ngspice/BiCMOS Process - Automotive/autohv-bicmos180-pdk/autohv_bicmos180_case.lib"
.param case=4
.param PROC_ON=0
.param MM_ON=0
Vb b 0 dc 0
XQ1 c1 b 0 NPN_HV AREA=1
Ecb cc 0 b 0 1
Vc1 cc c1 dc 0
Eb2 bb 0 b 0 1
Vb2 bb b2 dc 0
XQ2 c2 b2 0 NPN_HV AREA=1
Vcc dd 0 dc 2.0
Vc2 dd c2 dc 0
.control
set width=1000
dc Vb 0.3 1.1 0.005
echo TBL_BEGIN
print abs(i(Vc1)) abs(i(Vb)) abs(i(Vc2)) abs(i(Vb2))
echo TBL_END
.endc
.end
