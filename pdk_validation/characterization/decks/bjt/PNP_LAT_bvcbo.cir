* PNP_LAT BVCBO, emitter open (1 Gohm), AREA=1
* Generated by pdk_validation/characterization -- phase 2 harness.
* Instruments (ideal, not DUT): Vcc sweep through a 100 kohm ballast, Vc 0 V ammeter, Vb ideal 0 V, Reopen 1 Gohm
* Re-run standalone:  ngspice -b <this file>
.include "C:/Users/chris/ngspice/BiCMOS Process - Automotive/autohv-bicmos180-pdk/autohv_bicmos180_case.lib"
.param case=0
.param PROC_ON=0
.param MM_ON=0
XQ c b e PNP_LAT AREA=1
Vb b 0 dc 0
Reopen e 0 1e9
Rball s cx 100000.0
Vc cx c dc 0
Vcc s 0 dc 0
.control
set width=1000
dc Vcc 0 -60.0 -0.05
echo TBL_BEGIN
print abs(v(c)) abs(i(Vc))
echo TBL_END
.endc
.end
