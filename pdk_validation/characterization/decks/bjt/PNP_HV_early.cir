* PNP_HV output characteristic, fixed-Vbe and fixed-Ib benches, AREA=1
* Generated by pdk_validation/characterization -- phase 2 harness.
* Instruments (ideal, not DUT): Vbea ideal base voltage source, Iib ideal base current source, Vcc sweep, Vca/Vcb 0 V ammeters
* Re-run standalone:  ngspice -b <this file>
.include "C:/Users/chris/ngspice/BiCMOS Process - Automotive/autohv-bicmos180-pdk/autohv_bicmos180_case.lib"
.param case=0
.param PROC_ON=0
.param MM_ON=0
Vcc dd 0 dc 0
XQA ca ba 0 PNP_HV AREA=1
Vbea ba 0 dc -0.7386173753437494
Vca dd ca dc 0
XQB cb bb 0 PNP_HV AREA=1
Iib bb 0 dc 5.5e-06
Vcb dd cb dc 0
.control
set width=1000
dc Vcc -0.5 -5.0 -0.05
echo TBL_BEGIN
print abs(i(Vca)) abs(i(Vcb))
echo TBL_END
.endc
.end
