* PMOS12 Monte Carlo matched pair, W/L=10u/1u, MM_ON=1
* Generated by pdk_validation/characterization -- phase 2 harness.
* Instruments (ideal, not DUT): Vd1, Vd2, Vg -- ideal sources
* Re-run standalone:  ngspice -b <this file>
.include "C:/Users/chris/ngspice/BiCMOS Process - Automotive/autohv-bicmos180-pdk/autohv_bicmos180_case.lib"
.param case=0
.param PROC_ON=0
.param MM_ON=1
XM1 d1 g 0 0 PMOS12 W=10u L=1u
XM2 d2 g 0 0 PMOS12 W=10u L=1u
Vd1 d1 0 dc -6.0
Vd2 d2 0 dc -6.0
Vg g 0 dc -6.0
.control
op
print @m.xm1.m0[id] @m.xm2.m0[id] @m.xm1.m0[vth] @m.xm2.m0[vth]
.endc
.end
