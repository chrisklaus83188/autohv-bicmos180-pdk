* mc NDMOS200
* Generated by pdk_validation/characterization -- phase 2 harness.
* Re-run standalone:  ngspice -b <this file>
.include "C:/Users/chris/ngspice/BiCMOS Process - Automotive/autohv-bicmos180-pdk/autohv_bicmos180_case.lib"
.param case=0
.param PROC_ON=0
.param MM_ON=1
Ib 0 dg 0.0001
Vs 0 0 0
X0 dg dg 0 NDMOS200 W=13.4u L=8u
Vd1 d1 0 10.0
Vd2 d2 0 10.0
X1 d1 dg 0 NDMOS200 W=13.4u L=8u
X2 d2 dg 0 NDMOS200 W=13.4u L=8u
.control
set noaskquit
op
print i(Vd1) i(Vd2)
.endc
.end
