* DZ_24 forward IV, AREA=1
* Generated by pdk_validation/characterization -- phase 2 harness.
* Instruments (ideal, not DUT): Vs sweep through a 50 ohm ballast; v(a) is the device terminal voltage so the ballast drop is not counted
* Re-run standalone:  ngspice -b <this file>
.include "C:/Users/chris/ngspice/BiCMOS Process - Automotive/autohv-bicmos180-pdk/autohv_bicmos180_case.lib"
.param case=0
.param PROC_ON=0
.param MM_ON=0
XD a 0 DZ_24 AREA=1
Rball s a 50.0
Vs s 0 dc 0
.control
set width=1000
dc Vs 0 1.4 0.002
echo TBL_BEGIN
print v(a) abs(i(Vs))
echo TBL_END
.endc
.end
