* DZ_12 forward diffusion capacitance at 0.01 A, 1e+06 Hz, AREA=1
* Generated by pdk_validation/characterization -- phase 2 harness.
* Instruments (ideal, not DUT): Ib ideal current source: DC bias plus a 1 A AC probe, so v(a) reads out as the impedance directly
* Re-run standalone:  ngspice -b <this file>
.include "C:/Users/chris/ngspice/BiCMOS Process - Automotive/autohv-bicmos180-pdk/autohv_bicmos180_case.lib"
.param case=0
.param PROC_ON=0
.param MM_ON=0
XD a 0 DZ_12 AREA=1
Ib 0 a dc 0.01 ac 1
.control
set width=1000
op
print v(a)
ac lin 1 1e+06 1e+06
print real(v(a)) imag(v(a))
.endc
.end
