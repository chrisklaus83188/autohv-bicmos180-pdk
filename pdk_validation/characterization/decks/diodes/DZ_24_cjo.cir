* DZ_24 zero-bias junction capacitance at 1e+06 Hz, AREA=1
* Generated by pdk_validation/characterization -- phase 2 harness.
* Instruments (ideal, not DUT): Vk 1 V AC probe at 0 V DC
* Re-run standalone:  ngspice -b <this file>
.include "C:/Users/chris/ngspice/BiCMOS Process - Automotive/autohv-bicmos180-pdk/autohv_bicmos180_case.lib"
.param case=0
.param PROC_ON=0
.param MM_ON=0
XD 0 k DZ_24 AREA=1
Vk k 0 dc 0 ac 1
.control
set width=1000
ac lin 1 1e+06 1e+06
print imag(i(Vk))
.endc
.end
