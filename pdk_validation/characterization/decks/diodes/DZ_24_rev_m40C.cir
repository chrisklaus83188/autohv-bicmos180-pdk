* DZ_24 reverse breakdown, AREA=1, -40.0 degC
* Generated by pdk_validation/characterization -- phase 2 harness.
* Instruments (ideal, not DUT): Vs sweep through a 1 kohm ballast; v(k) is the device terminal voltage
* Re-run standalone:  ngspice -b <this file>
.include "C:/Users/chris/ngspice/BiCMOS Process - Automotive/autohv-bicmos180-pdk/autohv_bicmos180_case.lib"
.param case=0
.param PROC_ON=0
.param MM_ON=0
.options temp=-40.0
XD 0 k DZ_24 AREA=1
Rball s k 1000.0
Vs s 0 dc 0
.control
set width=1000
dc Vs 0 38.0 0.019
echo TBL_BEGIN
print v(k) abs(i(Vs))
echo TBL_END
.endc
.end
