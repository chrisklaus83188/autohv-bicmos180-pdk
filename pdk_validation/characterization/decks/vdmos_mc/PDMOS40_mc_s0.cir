* PDMOS40 Monte Carlo matched pair at W_REF=10u, MM_ON=1
* Generated by pdk_validation/characterization -- phase 2 harness.
* Instruments (ideal, not DUT): Vga/Vgb/Vda/Vdb -- ideal sources
* Re-run standalone:  ngspice -b <this file>
.include "C:/Users/chris/ngspice/BiCMOS Process - Automotive/autohv-bicmos180-pdk/autohv_bicmos180_case.lib"
.param case=0
.param PROC_ON=0
.param MM_ON=1
XA da ga 0 PDMOS40 W=10u
XB db gb 0 PDMOS40 W=10u
Vga ga 0 dc -1.6
Vgb gb 0 dc -1.6
Vda da 0 dc -1.0
Vdb db 0 dc -1.0
.control
op
print v(xa.g_int) v(xb.g_int)
print @m.xa.m0[id] @m.xb.m0[id]
.endc
.end
