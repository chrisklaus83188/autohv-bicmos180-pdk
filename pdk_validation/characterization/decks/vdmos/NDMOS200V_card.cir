* NDMOS200V model-card readback (TT, 27 degC)
* Generated by pdk_validation/characterization -- phase 2 harness.
* Instruments (ideal, not DUT): Vd, Vg -- ideal sources, held at 0 for a trivial op
* Re-run standalone:  ngspice -b <this file>
.include "C:/Users/chris/ngspice/BiCMOS Process - Automotive/autohv-bicmos180-pdk/autohv_bicmos180_case.lib"
.param case=0
.param PROC_ON=0
.param MM_ON=0
XH1 d g 0 NDMOS200V W=10u L=8u
Vd d 0 dc 0
Vg g 0 dc 0
.control
op
print @NDMOS200V_INT[vto] @NDMOS200V_INT[kp] @NDMOS200V_INT[theta] @NDMOS200V_INT[bv] @NDMOS200V_INT[tt] @NDMOS200V_INT[rd] @NDMOS200V_INT[rs] @NDMOS200V_INT[cgs] @NDMOS200V_INT[cgdmax] @NDMOS200V_INT[cgdmin] @NDMOS200V_INT[cjo] @NDMOS200V_INT[lambda] @NDMOS200V_INT[ksubthres]
.endc
.end
