* PDMOS200V model-card readback (TT, 27 degC)
* Generated by pdk_validation/characterization -- phase 2 harness.
* Instruments (ideal, not DUT): Vd, Vg -- ideal sources, held at 0 for a trivial op
* Re-run standalone:  ngspice -b <this file>
.include "C:/Users/chris/ngspice/BiCMOS Process - Automotive/autohv-bicmos180-pdk/autohv_bicmos180_case.lib"
.param case=0
.param PROC_ON=0
.param MM_ON=0
XH1 d g 0 PDMOS200V W=10u L=8u
Vd d 0 dc 0
Vg g 0 dc 0
.control
op
print @PDMOS200V_INT[vto] @PDMOS200V_INT[kp] @PDMOS200V_INT[theta] @PDMOS200V_INT[bv] @PDMOS200V_INT[tt] @PDMOS200V_INT[rd] @PDMOS200V_INT[rs] @PDMOS200V_INT[cgs] @PDMOS200V_INT[cgdmax] @PDMOS200V_INT[cgdmin] @PDMOS200V_INT[cjo] @PDMOS200V_INT[lambda] @PDMOS200V_INT[ksubthres]
.endc
.end
