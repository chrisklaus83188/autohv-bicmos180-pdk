* NDMOS200 cap reconciliation -- CHANGELOG/coss_check variant, Vds=100 V
* Generated by pdk_validation/characterization -- phase 2 harness.
* Instruments (ideal, not DUT): VB 1 V AC probe at 1 MHz; Vg ideal DC
* Re-run standalone:  ngspice -b <this file>
.include "C:/Users/chris/ngspice/BiCMOS Process - Automotive/autohv-bicmos180-pdk/autohv_bicmos180_case.lib"
.param case=0
.param PROC_ON=0
.param MM_ON=0
VB d 0 DC 100 AC 1
Vg g 0 DC 0
XN5 d g 0 NDMOS200 W=40u L=8u
.ac lin 1 1meg 1meg
.control
run
let cdrain = abs(i(VB))/(2*PI*1e6)
print cdrain
.endc
.end
