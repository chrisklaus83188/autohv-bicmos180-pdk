* NDMOS200 model-card readback (TT, 27 degC)
* Generated by pdk_validation/characterization -- phase 2 harness.
* Instruments (ideal, not DUT): Vd, Vg -- ideal sources, held at 0 for a trivial op
* Re-run standalone:  ngspice -b <this file>
.include "C:/Users/chris/ngspice/BiCMOS Process - Automotive/autohv-bicmos180-pdk/autohv_bicmos180_case.lib"
.param case=0
.param PROC_ON=0
.param MM_ON=0
XH1 d g 0 NDMOS200 W=10u L=8u
Vd d 0 dc 0
Vg g 0 dc 0
.control
op
print @NDMOS200_INT[vto] @NDMOS200_INT[kp] @NDMOS200_INT[theta] @NDMOS200_INT[bv] @NDMOS200_INT[tt] @NDMOS200_INT[rd] @NDMOS200_INT[rs] @NDMOS200_INT[cgs] @NDMOS200_INT[cgdmax] @NDMOS200_INT[cgdmin] @NDMOS200_INT[cjo] @NDMOS200_INT[lambda] @NDMOS200_INT[ksubthres]
.endc
.end
