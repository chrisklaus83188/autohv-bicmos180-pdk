* PDMOS60 model-card readback (TT, 27 degC)
* Generated by pdk_validation/characterization -- phase 2 harness.
* Instruments (ideal, not DUT): Vd, Vg -- ideal sources, held at 0 for a trivial op
* Re-run standalone:  ngspice -b <this file>
.include "C:/Users/chris/ngspice/BiCMOS Process - Automotive/autohv-bicmos180-pdk/autohv_bicmos180_case.lib"
.param case=0
.param PROC_ON=0
.param MM_ON=0
XH1 d g 0 PDMOS60 W=10u
Vd d 0 dc 0
Vg g 0 dc 0
.control
op
print @PDMOS60_INT[vto] @PDMOS60_INT[kp] @PDMOS60_INT[theta] @PDMOS60_INT[bv] @PDMOS60_INT[tt] @PDMOS60_INT[rd] @PDMOS60_INT[rs] @PDMOS60_INT[cgs] @PDMOS60_INT[cgdmax] @PDMOS60_INT[cgdmin] @PDMOS60_INT[cjo] @PDMOS60_INT[lambda] @PDMOS60_INT[ksubthres]
.endc
.end
