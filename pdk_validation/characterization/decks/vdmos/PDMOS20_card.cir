* PDMOS20 model-card readback (TT, 27 degC)
* Generated by pdk_validation/characterization -- phase 2 harness.
* Instruments (ideal, not DUT): Vd, Vg -- ideal sources, held at 0 for a trivial op
* Re-run standalone:  ngspice -b <this file>
.include "C:/Users/chris/ngspice/BiCMOS Process - Automotive/autohv-bicmos180-pdk/autohv_bicmos180_case.lib"
.param case=0
.param PROC_ON=0
.param MM_ON=0
XH1 d g 0 PDMOS20 W=10u
Vd d 0 dc 0
Vg g 0 dc 0
.control
op
print @PDMOS20_INT[vto] @PDMOS20_INT[kp] @PDMOS20_INT[theta] @PDMOS20_INT[bv] @PDMOS20_INT[tt] @PDMOS20_INT[rd] @PDMOS20_INT[rs] @PDMOS20_INT[cgs] @PDMOS20_INT[cgdmax] @PDMOS20_INT[cgdmin] @PDMOS20_INT[cjo] @PDMOS20_INT[lambda] @PDMOS20_INT[ksubthres]
.endc
.end
