* PDMOS80V model-card readback (TT, 27 degC)
* Generated by pdk_validation/characterization -- phase 2 harness.
* Instruments (ideal, not DUT): Vd, Vg -- ideal sources, held at 0 for a trivial op
* Re-run standalone:  ngspice -b <this file>
.include "C:/Users/chris/ngspice/BiCMOS Process - Automotive/autohv-bicmos180-pdk/autohv_bicmos180_case.lib"
.param case=0
.param PROC_ON=0
.param MM_ON=0
XH1 d g 0 PDMOS80V W=10u
Vd d 0 dc 0
Vg g 0 dc 0
.control
op
print @PDMOS80V_INT[vto] @PDMOS80V_INT[kp] @PDMOS80V_INT[theta] @PDMOS80V_INT[bv] @PDMOS80V_INT[tt] @PDMOS80V_INT[rd] @PDMOS80V_INT[rs] @PDMOS80V_INT[cgs] @PDMOS80V_INT[cgdmax] @PDMOS80V_INT[cgdmin] @PDMOS80V_INT[cjo] @PDMOS80V_INT[lambda] @PDMOS80V_INT[ksubthres]
.endc
.end
