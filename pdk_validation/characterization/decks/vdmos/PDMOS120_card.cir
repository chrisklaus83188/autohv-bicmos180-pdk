* PDMOS120 model-card readback (TT, 27 degC)
* Generated by pdk_validation/characterization -- phase 2 harness.
* Instruments (ideal, not DUT): Vd, Vg -- ideal sources, held at 0 for a trivial op
* Re-run standalone:  ngspice -b <this file>
.include "C:/Users/chris/ngspice/BiCMOS Process - Automotive/autohv-bicmos180-pdk/autohv_bicmos180_case.lib"
.param case=0
.param PROC_ON=0
.param MM_ON=0
XH1 d g 0 PDMOS120 W=10u
Vd d 0 dc 0
Vg g 0 dc 0
.control
op
print @PDMOS120_INT[vto] @PDMOS120_INT[kp] @PDMOS120_INT[theta] @PDMOS120_INT[bv] @PDMOS120_INT[tt] @PDMOS120_INT[rd] @PDMOS120_INT[rs] @PDMOS120_INT[cgs] @PDMOS120_INT[cgdmax] @PDMOS120_INT[cgdmin] @PDMOS120_INT[cjo] @PDMOS120_INT[lambda] @PDMOS120_INT[ksubthres]
.endc
.end
