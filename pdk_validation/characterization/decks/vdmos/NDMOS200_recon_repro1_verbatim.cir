* NDMOS200 cap reconciliation -- HANDOFF_vdmos_caps.md Repro-1, VERBATIM
* Generated by pdk_validation/characterization -- phase 2 harness.
* Instruments (ideal, not DUT): VB 1 V AC probe at 1 MHz; Vg ideal DC
* Re-run standalone:  ngspice -b <this file>
.include "C:/Users/chris/ngspice/BiCMOS Process - Automotive/autohv-bicmos180-pdk/autohv_bicmos180_case.lib"
.param case=0
.param PROC_ON=0
.param MM_ON=0
.param SOA_ON=1
VB  d 0 DC {VBIAS} AC 1
Vg  g 0 DC 0
XN5 d g 0 NDMOS200 W=40u L=8u
.param VBIAS=0.1
.ac lin 1 1meg 1meg
.control
  foreach vb 0.1 12 100 200
    alter VB dc=$vb
    run
    let cdrain = abs(i(VB))/(2*3.14159265*1e6*1)
    echo "Vds=$vb" ; print cdrain
  end
.endc
.end
