* NDMOS80 DC gate current vs Vgs (Rcond artifact probe)
* Generated by pdk_validation/characterization -- phase 2 harness.
* Instruments (ideal, not DUT): Vg (gate sweep), Vd -- ideal sources
* Re-run standalone:  ngspice -b <this file>
.include "C:/Users/chris/ngspice/BiCMOS Process - Automotive/autohv-bicmos180-pdk/autohv_bicmos180_case.lib"
.param case=0
.param PROC_ON=0
.param MM_ON=0
XH1 d g 0 NDMOS80 W=10u
Vd d 0 dc 0.1
Vg g 0 dc 0
.control
dc Vg 0 12.0 0.05
echo TBL_BEGIN
print abs(i(Vg))
echo TBL_END
.endc
.end
