* PDMOS20V model-card readback (TT, 27 degC)
* Generated by pdk_validation/characterization -- phase 2 harness.
* Instruments (ideal, not DUT): Vd, Vg -- ideal sources, held at 0 for a trivial op
* Re-run standalone:  ngspice -b <this file>
.include "C:/Users/chris/ngspice/BiCMOS Process - Automotive/autohv-bicmos180-pdk/autohv_bicmos180_case.lib"
.param case=0
.param PROC_ON=0
.param MM_ON=0
XH1 d g 0 PDMOS20V W=10u
Vd d 0 dc 0
Vg g 0 dc 0
.control
op
print @PDMOS20V_INT[vto] @PDMOS20V_INT[kp] @PDMOS20V_INT[theta] @PDMOS20V_INT[bv] @PDMOS20V_INT[tt] @PDMOS20V_INT[rd] @PDMOS20V_INT[rs] @PDMOS20V_INT[cgs] @PDMOS20V_INT[cgdmax] @PDMOS20V_INT[cgdmin] @PDMOS20V_INT[cjo] @PDMOS20V_INT[lambda] @PDMOS20V_INT[ksubthres]
.endc
.end
