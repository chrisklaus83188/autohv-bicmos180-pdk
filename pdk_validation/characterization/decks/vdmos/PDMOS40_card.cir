* PDMOS40 model-card readback (TT, 27 degC)
* Generated by pdk_validation/characterization -- phase 2 harness.
* Instruments (ideal, not DUT): Vd, Vg -- ideal sources, held at 0 for a trivial op
* Re-run standalone:  ngspice -b <this file>
.include "C:/Users/chris/ngspice/BiCMOS Process - Automotive/autohv-bicmos180-pdk/autohv_bicmos180_case.lib"
.param case=0
.param PROC_ON=0
.param MM_ON=0
XH1 d g 0 PDMOS40 W=10u
Vd d 0 dc 0
Vg g 0 dc 0
.control
op
print @PDMOS40_INT[vto] @PDMOS40_INT[kp] @PDMOS40_INT[theta] @PDMOS40_INT[bv] @PDMOS40_INT[tt] @PDMOS40_INT[rd] @PDMOS40_INT[rs] @PDMOS40_INT[cgs] @PDMOS40_INT[cgdmax] @PDMOS40_INT[cgdmin] @PDMOS40_INT[cjo] @PDMOS40_INT[lambda] @PDMOS40_INT[ksubthres]
.endc
.end
