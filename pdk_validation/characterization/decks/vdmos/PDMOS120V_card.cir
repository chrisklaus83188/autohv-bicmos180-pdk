* PDMOS120V model-card readback (TT, 27 degC)
* Generated by pdk_validation/characterization -- phase 2 harness.
* Instruments (ideal, not DUT): Vd, Vg -- ideal sources, held at 0 for a trivial op
* Re-run standalone:  ngspice -b <this file>
.include "C:/Users/chris/ngspice/BiCMOS Process - Automotive/autohv-bicmos180-pdk/autohv_bicmos180_case.lib"
.param case=0
.param PROC_ON=0
.param MM_ON=0
XH1 d g 0 PDMOS120V W=10u
Vd d 0 dc 0
Vg g 0 dc 0
.control
op
print @PDMOS120V_INT[vto] @PDMOS120V_INT[kp] @PDMOS120V_INT[theta] @PDMOS120V_INT[bv] @PDMOS120V_INT[tt] @PDMOS120V_INT[rd] @PDMOS120V_INT[rs] @PDMOS120V_INT[cgs] @PDMOS120V_INT[cgdmax] @PDMOS120V_INT[cgdmin] @PDMOS120V_INT[cjo] @PDMOS120V_INT[lambda] @PDMOS120V_INT[ksubthres]
.endc
.end
