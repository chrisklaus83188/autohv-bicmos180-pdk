* NDMOS40 model-card readback (TT, 27 degC)
* Generated by pdk_validation/characterization -- phase 2 harness.
* Instruments (ideal, not DUT): Vd, Vg -- ideal sources, held at 0 for a trivial op
* Re-run standalone:  ngspice -b <this file>
.include "C:/Users/chris/ngspice/BiCMOS Process - Automotive/autohv-bicmos180-pdk/autohv_bicmos180_case.lib"
.param case=0
.param PROC_ON=0
.param MM_ON=0
XH1 d g 0 NDMOS40 W=10u
Vd d 0 dc 0
Vg g 0 dc 0
.control
op
print @NDMOS40_INT[vto] @NDMOS40_INT[kp] @NDMOS40_INT[theta] @NDMOS40_INT[bv] @NDMOS40_INT[tt] @NDMOS40_INT[rd] @NDMOS40_INT[rs] @NDMOS40_INT[cgs] @NDMOS40_INT[cgdmax] @NDMOS40_INT[cgdmin] @NDMOS40_INT[cjo] @NDMOS40_INT[lambda] @NDMOS40_INT[ksubthres]
.endc
.end
