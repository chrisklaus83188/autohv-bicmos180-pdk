* NDMOS120 model-card readback (TT, 27 degC)
* Generated by pdk_validation/characterization -- phase 2 harness.
* Instruments (ideal, not DUT): Vd, Vg -- ideal sources, held at 0 for a trivial op
* Re-run standalone:  ngspice -b <this file>
.include "C:/Users/chris/ngspice/BiCMOS Process - Automotive/autohv-bicmos180-pdk/autohv_bicmos180_case.lib"
.param case=0
.param PROC_ON=0
.param MM_ON=0
XH1 d g 0 NDMOS120 W=10u
Vd d 0 dc 0
Vg g 0 dc 0
.control
op
print @NDMOS120_INT[vto] @NDMOS120_INT[kp] @NDMOS120_INT[theta] @NDMOS120_INT[bv] @NDMOS120_INT[tt] @NDMOS120_INT[rd] @NDMOS120_INT[rs] @NDMOS120_INT[cgs] @NDMOS120_INT[cgdmax] @NDMOS120_INT[cgdmin] @NDMOS120_INT[cjo] @NDMOS120_INT[lambda] @NDMOS120_INT[ksubthres]
.endc
.end
