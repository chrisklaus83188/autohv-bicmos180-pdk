* NDMOS40 terminal C at Vds=+12 V, Vgs=+0 V (channel off)
* Generated by pdk_validation/characterization -- phase 2 harness.
* Instruments (ideal, not DUT): Vd/Vg 1 V AC probes at 1e+06 Hz; DC values are ideal bias sources
* Re-run standalone:  ngspice -b <this file>
.include "C:/Users/chris/ngspice/BiCMOS Process - Automotive/autohv-bicmos180-pdk/autohv_bicmos180_case.lib"
.param case=0
.param PROC_ON=0
.param MM_ON=0
XH1 d g 0 NDMOS40 W=10u
Vd d 0 dc 12.0 ac 1
Vg g 0 dc 0.0 ac 0
.control
ac lin 1 1e+06 1e+06
let coss = abs(imag(i(Vd)))
let crss = abs(imag(i(Vg)))
print coss crss
alter Vd acmag=0
alter Vg acmag=1
ac lin 1 1e+06 1e+06
let ciss = abs(imag(i(Vg)))
print ciss
.endc
.end
