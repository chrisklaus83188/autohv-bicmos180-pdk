* DNMOS20 model-card readback (TT, 27 degC)
* Generated by pdk_validation/characterization -- phase 2 harness.
* Instruments (ideal, not DUT): Vd, Vg -- ideal sources, held at 0 for a trivial op
* Re-run standalone:  ngspice -b <this file>
.include "C:/Users/chris/ngspice/BiCMOS Process - Automotive/autohv-bicmos180-pdk/autohv_bicmos180_case.lib"
.param case=0
.param PROC_ON=0
.param MM_ON=0
XH1 d g 0 DNMOS20 W=10u
Vd d 0 dc 0
Vg g 0 dc 0
.control
op
print @DNMOS20_INT[vto] @DNMOS20_INT[kp] @DNMOS20_INT[theta] @DNMOS20_INT[bv] @DNMOS20_INT[tt] @DNMOS20_INT[rd] @DNMOS20_INT[rs] @DNMOS20_INT[cgs] @DNMOS20_INT[cgdmax] @DNMOS20_INT[cgdmin] @DNMOS20_INT[cjo] @DNMOS20_INT[lambda] @DNMOS20_INT[ksubthres]
.endc
.end
