* PDMOS200 model-card readback (TT, 27 degC)
* Generated by pdk_validation/characterization -- phase 2 harness.
* Instruments (ideal, not DUT): Vd, Vg -- ideal sources, held at 0 for a trivial op
* Re-run standalone:  ngspice -b <this file>
.include "C:/Users/chris/ngspice/BiCMOS Process - Automotive/autohv-bicmos180-pdk/autohv_bicmos180_case.lib"
.param case=0
.param PROC_ON=0
.param MM_ON=0
XH1 d g 0 PDMOS200 W=10u L=8u
Vd d 0 dc 0
Vg g 0 dc 0
.control
op
print @PDMOS200_INT[vto] @PDMOS200_INT[kp] @PDMOS200_INT[theta] @PDMOS200_INT[bv] @PDMOS200_INT[tt] @PDMOS200_INT[rd] @PDMOS200_INT[rs] @PDMOS200_INT[cgs] @PDMOS200_INT[cgdmax] @PDMOS200_INT[cgdmin] @PDMOS200_INT[cjo] @PDMOS200_INT[lambda] @PDMOS200_INT[ksubthres]
.endc
.end
