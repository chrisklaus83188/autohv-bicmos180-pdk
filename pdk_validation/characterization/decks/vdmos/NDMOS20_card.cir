* NDMOS20 model-card readback (TT, 27 degC)
* Generated by pdk_validation/characterization -- phase 2 harness.
* Instruments (ideal, not DUT): Vd, Vg -- ideal sources, held at 0 for a trivial op
* Re-run standalone:  ngspice -b <this file>
.include "C:/Users/chris/ngspice/BiCMOS Process - Automotive/autohv-bicmos180-pdk/autohv_bicmos180_case.lib"
.param case=0
.param PROC_ON=0
.param MM_ON=0
XH1 d g 0 NDMOS20 W=10u
Vd d 0 dc 0
Vg g 0 dc 0
.control
op
print @NDMOS20_INT[vto] @NDMOS20_INT[kp] @NDMOS20_INT[theta] @NDMOS20_INT[bv] @NDMOS20_INT[tt] @NDMOS20_INT[rd] @NDMOS20_INT[rs] @NDMOS20_INT[cgs] @NDMOS20_INT[cgdmax] @NDMOS20_INT[cgdmin] @NDMOS20_INT[cjo] @NDMOS20_INT[lambda] @NDMOS20_INT[ksubthres]
.endc
.end
