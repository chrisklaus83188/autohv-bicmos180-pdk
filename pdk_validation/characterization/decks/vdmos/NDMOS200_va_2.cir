* NDMOS200 VA gds point 2: Vgs=+2.75 V, Vds=+120 V
* Generated by pdk_validation/characterization -- phase 2 harness.
* Instruments (ideal, not DUT): Vd, Vg -- ideal sources
* Re-run standalone:  ngspice -b <this file>
.include "C:/Users/chris/ngspice/BiCMOS Process - Automotive/autohv-bicmos180-pdk/autohv_bicmos180_case.lib"
.param case=0
.param PROC_ON=0
.param MM_ON=0
XH1 d g 0 NDMOS200 W=10u L=8u
Vd d 0 dc 120.0
Vg g 0 dc 2.75
.control
op
print @m.xh1.m0[id] @m.xh1.m0[gm]
print i(Vd) i(Vg)
.endc
.end
