* PDMOS60V model-card readback (TT, 27 degC)
* Generated by pdk_validation/characterization -- phase 2 harness.
* Instruments (ideal, not DUT): Vd, Vg -- ideal sources, held at 0 for a trivial op
* Re-run standalone:  ngspice -b <this file>
.include "C:/Users/chris/ngspice/BiCMOS Process - Automotive/autohv-bicmos180-pdk/autohv_bicmos180_case.lib"
.param case=0
.param PROC_ON=0
.param MM_ON=0
XH1 d g 0 PDMOS60V W=10u
Vd d 0 dc 0
Vg g 0 dc 0
.control
op
print @PDMOS60V_INT[vto] @PDMOS60V_INT[kp] @PDMOS60V_INT[theta] @PDMOS60V_INT[bv] @PDMOS60V_INT[tt] @PDMOS60V_INT[rd] @PDMOS60V_INT[rs] @PDMOS60V_INT[cgs] @PDMOS60V_INT[cgdmax] @PDMOS60V_INT[cgdmin] @PDMOS60V_INT[cjo] @PDMOS60V_INT[lambda] @PDMOS60V_INT[ksubthres]
.endc
.end
