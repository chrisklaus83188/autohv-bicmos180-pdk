* PDMOS200 breakdown ramp, corner SF, gate off (Vgs=+0 V), L=8u
* Generated by pdk_validation/characterization -- phase 2 harness.
* Instruments (ideal, not DUT): Vd (drain ramp), Vg -- ideal sources
* Re-run standalone:  ngspice -b <this file>
.include "C:/Users/chris/ngspice/BiCMOS Process - Automotive/autohv-bicmos180-pdk/autohv_bicmos180_case.lib"
.param case=4
.param PROC_ON=0
.param MM_ON=0
XH1 d g 0 PDMOS200 W=10u L=8u
Vd d 0 dc 0
Vg g 0 dc 0.0
.control
dc Vd -184.0 -253.00000000000003 -0.115
echo TBL_BEGIN
print abs(i(Vd))
echo TBL_END
.endc
.end
