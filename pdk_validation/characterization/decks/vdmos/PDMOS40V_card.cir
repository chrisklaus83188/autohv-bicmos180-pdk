* PDMOS40V model-card readback (TT, 27 degC)
* Generated by pdk_validation/characterization -- phase 2 harness.
* Instruments (ideal, not DUT): Vd, Vg -- ideal sources, held at 0 for a trivial op
* Re-run standalone:  ngspice -b <this file>
.include "C:/Users/chris/ngspice/BiCMOS Process - Automotive/autohv-bicmos180-pdk/autohv_bicmos180_case.lib"
.param case=0
.param PROC_ON=0
.param MM_ON=0
XH1 d g 0 PDMOS40V W=10u
Vd d 0 dc 0
Vg g 0 dc 0
.control
op
print @PDMOS40V_INT[vto] @PDMOS40V_INT[kp] @PDMOS40V_INT[theta] @PDMOS40V_INT[bv] @PDMOS40V_INT[tt] @PDMOS40V_INT[rd] @PDMOS40V_INT[rs] @PDMOS40V_INT[cgs] @PDMOS40V_INT[cgdmax] @PDMOS40V_INT[cgdmin] @PDMOS40V_INT[cjo] @PDMOS40V_INT[lambda] @PDMOS40V_INT[ksubthres]
.endc
.end
