* NDMOS80 model-card readback (TT, 27 degC) -- d4
* Generated by pdk_validation/characterization -- phase 2 harness.
* Instruments (ideal, not DUT): Vd, Vg -- ideal sources at 0 V for a trivial op
* Re-run standalone:  ngspice -b <this file>
.include "C:/Users/chris/ngspice/BiCMOS Process - Automotive/autohv-bicmos180-pdk/autohv_bicmos180_case.lib"
.include "C:/Users/chris/ngspice/BiCMOS Process - Automotive/autohv-bicmos180-pdk/pdk_validation/characterization/results/local_models/NDMOS80_d4.mod"
.param case=0
.param PROC_ON=0
.param MM_ON=0
M0 d g 0 NDMOS80_D4 m=1
Vd d 0 dc 0
Vg g 0 dc 0
.control
set width=1000
op
print @NDMOS80_D4[vto] @NDMOS80_D4[kp] @NDMOS80_D4[theta] @NDMOS80_D4[lambda] @NDMOS80_D4[rd] @NDMOS80_D4[rs] @NDMOS80_D4[ksubthres] @NDMOS80_D4[mtriode] @NDMOS80_D4[bv]
.endc
.end
