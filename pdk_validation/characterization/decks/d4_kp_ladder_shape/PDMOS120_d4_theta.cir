* PDMOS120 [d4] strong-inversion Id-Vg (theta): Vds=-10 V
* Generated by pdk_validation/characterization -- phase 2 harness.
* Instruments (ideal, not DUT): Vd (drain bias), Vg (gate sweep) -- ideal sources
* Re-run standalone:  ngspice -b <this file>
.include "C:/Users/chris/ngspice/BiCMOS Process - Automotive/autohv-bicmos180-pdk/autohv_bicmos180_case.lib"
.include "C:/Users/chris/ngspice/BiCMOS Process - Automotive/autohv-bicmos180-pdk/pdk_validation/characterization/results/local_models/PDMOS120_d4.mod"
.param case=0
.param PROC_ON=0
.param MM_ON=0
M0 d g 0 PDMOS120_D4 m=1
Vd d 0 dc -10.0
Vg g 0 dc 0
.control
set width=1000
dc Vg -1.75 -5.25 -0.05
echo TBL_BEGIN
print abs(i(Vd))
echo TBL_END
.endc
.end
