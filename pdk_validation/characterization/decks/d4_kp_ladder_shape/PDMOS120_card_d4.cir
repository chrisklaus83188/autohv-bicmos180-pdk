* PDMOS120 model-card readback (TT, 27 degC) -- d4
* Generated by pdk_validation/characterization -- phase 2 harness.
* Instruments (ideal, not DUT): Vd, Vg -- ideal sources at 0 V for a trivial op
* Re-run standalone:  ngspice -b <this file>
.include "C:/Users/chris/ngspice/BiCMOS Process - Automotive/autohv-bicmos180-pdk/autohv_bicmos180_case.lib"
.include "C:/Users/chris/ngspice/BiCMOS Process - Automotive/autohv-bicmos180-pdk/pdk_validation/characterization/results/local_models/PDMOS120_d4.mod"
.param case=0
.param PROC_ON=0
.param MM_ON=0
M0 d g 0 PDMOS120_D4 m=1
Vd d 0 dc 0
Vg g 0 dc 0
.control
set width=1000
op
print @PDMOS120_D4[vto] @PDMOS120_D4[kp] @PDMOS120_D4[theta] @PDMOS120_D4[lambda] @PDMOS120_D4[rd] @PDMOS120_D4[rs] @PDMOS120_D4[ksubthres] @PDMOS120_D4[mtriode] @PDMOS120_D4[bv]
.endc
.end
