* NDMOS200 model-card readback (TT, 27 degC) -- d4
* Generated by pdk_validation/characterization -- phase 2 harness.
* Instruments (ideal, not DUT): Vd, Vg -- ideal sources at 0 V for a trivial op
* Re-run standalone:  ngspice -b <this file>
.include "C:/Users/chris/ngspice/BiCMOS Process - Automotive/autohv-bicmos180-pdk/autohv_bicmos180_case.lib"
.include "C:/Users/chris/ngspice/BiCMOS Process - Automotive/autohv-bicmos180-pdk/pdk_validation/characterization/results/local_models/NDMOS200_d4.mod"
.param case=0
.param PROC_ON=0
.param MM_ON=0
M0 d g 0 NDMOS200_D4 m=1
Vd d 0 dc 0
Vg g 0 dc 0
.control
set width=1000
op
print @NDMOS200_D4[vto] @NDMOS200_D4[kp] @NDMOS200_D4[theta] @NDMOS200_D4[lambda] @NDMOS200_D4[rd] @NDMOS200_D4[rs] @NDMOS200_D4[ksubthres] @NDMOS200_D4[mtriode] @NDMOS200_D4[bv]
.endc
.end
