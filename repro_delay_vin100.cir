.title chuba14f dynamic-transient repro: delay_vin100 (FF, VIN=100, -40C)
.include "autohv_bicmos180_case.lib"
.param case=1
.param PROC_ON=0
.param MM_ON=0
.options temp=-40

.subckt HSL high low vbiasc out vss wp=30u lp=5u wc=60u lc=5u wrs=1u lrs=90u wro=1u lro=43u msr=0 msm=0 msc=0 msrs=0 msro=0
X_M_ref refg refg high PDMOS200 W={wp} L={lp} MM_SIGMA={msr}
X_R_ref refg low RPOLY_HI W={wrs} L={lrs} MM_SIGMA={msrs}
X_M_mir mird refg high PDMOS200 W={wp} L={lp} MM_SIGMA={msm}
R_pull mird vss 10Meg
X_M_casc mird vbiasc out NDMOS200 W={wc} L={lc} MM_SIGMA={msc}
X_R_out out vss RPOLY_HI W={wro} L={lro} MM_SIGMA={msro}
.ends HSL

.subckt CMP vinp vinn vout vdd vss vbn wt=3u lt=2u wi=22u li=2u wl=10u ll=2u mst=0 md1=0 md2=0 ml1=0 ml2=0
X_t  tail vbn  vss vss NMOS50 W={wt} L={lt} MM_SIGMA={mst}
X_d1 d1   vinp tail vss NMOS50 W={wi} L={li} MM_SIGMA={md1}
X_d2 d2   vinn tail vss NMOS50 W={wi} L={li} MM_SIGMA={md2}
X_l1 d1   d1   vdd vdd PMOS50 W={wl} L={ll} MM_SIGMA={ml1}
X_l2 d2   d1   vdd vdd PMOS50 W={wl} L={ll} MM_SIGMA={ml2}
X_inA voutn d2    vss vss NMOS50 W=10u L=0.5u
X_ipA voutn d2    vdd vdd PMOS50 W=20u L=0.5u
X_inB vout  voutn vss vss NMOS50 W=10u L=0.5u
X_ipB vout  voutn vdd vdd PMOS50 W=20u L=0.5u
.ends CMP

X_bias vbn vbn 0 0 NMOS50 W=10u L=1u MM_SIGMA=0.0000
X_R_bias vcc vbn RPOLY_HI W=0.5u L=270u MM_SIGMA=0.0000

X_hsl_cp vcp vin vcasc v_cp_lo 0 HSL wp=30u lp=5u wc=12u lc=5u wrs=1u lrs=90u wro=1.5u lro=75u msr=0.0000 msm=0.0000 msc=0.0000 msrs=0.0000 msro=0.0000
X_hsl_43 vref43 vin vcasc v_43_lo 0 HSL wp=30u lp=5u wc=12u lc=5u wrs=1u lrs=90u wro=1.5u lro=75u msr=0.0000 msm=0.0000 msc=0.0000 msrs=0.0000 msro=0.0000
X_hsl_57 vref57 vin vcasc v_57_lo 0 HSL wp=30u lp=5u wc=12u lc=5u wrs=1u lrs=90u wro=1.5u lro=75u msr=0.0000 msm=0.0000 msc=0.0000 msrs=0.0000 msro=0.0000
X_hsl_vccm vccm vin vcasc v_vccm_lo 0 HSL wp=30u lp=5u wc=12u lc=5u wrs=1u lrs=90u wro=1.5u lro=75u msr=0.0000 msm=0.0000 msc=0.0000 msrs=0.0000 msro=0.0000

X_c_43 v_cp_lo v_43_lo out_above_43 vcc 0 vbn CMP wt=10u lt=1u wi=40u li=2u wl=12u ll=3u mst=0.0000 md1=0.0000 md2=0.0000 ml1=0.0000 ml2=0.0000
X_c_57 v_cp_lo v_57_lo out_above_57 vcc 0 vbn CMP wt=10u lt=1u wi=40u li=2u wl=12u ll=3u mst=0.0000 md1=0.0000 md2=0.0000 ml1=0.0000 ml2=0.0000
X_c_vccm v_cp_lo v_vccm_lo out_above_vccm vcc 0 vbn CMP wt=10u lt=1u wi=40u li=2u wl=12u ll=3u mst=0.0000 md1=0.0000 md2=0.0000 ml1=0.0000 ml2=0.0000

C_dbm_cp   x_hsl_cp.mird vcp 160.0f
C_dbr_cp   x_hsl_cp.refg vcp 80.0f
C_load_cp_lo v_cp_lo 0 250f
C_load_43 v_43_lo 0 250f
C_load_57 v_57_lo 0 250f
C_load_vccm v_vccm_lo 0 250f
C_par_out43 out_above_43 0 100f
C_par_out57 out_above_57 0 100f
C_par_outvccm out_above_vccm 0 100f
V_vcc  vcc 0 PWL(0 0 125.000u 5.5)
V_vin  vin 0 PWL(0 0 125.000u 100)
B_cp_internal vcp_internal 0 V=V(vin)+V(vtest)
V_cp_probe vcp vcp_internal DC 0
V_test vtest 0 PWL(0 3.5 130.000u 3.5 130.010u 6.5)
V_casc vcasc 0 PWL(0 0 125.000u 4.0)
B_ref43 vref43 0 V=V(vin)+4.3
B_ref57 vref57 0 V=V(vin)+5.7
B_vccm vccm 0 V=V(vin)+V(vcc)-0.2
.control
.options reltol=5e-3 abstol=1e-9 vntol=1e-5
tran 0.02u 140.000u
meas tran tdly_43   trig v(vtest) val=4.3            rise=1 targ v(out_above_43)   val=2.5 rise=1 td=129.900u
meas tran tdly_vccm trig v(vtest) val=5.3000 rise=1 targ v(out_above_vccm) val=2.5 rise=1 td=129.900u
meas tran tdly_57   trig v(vtest) val=5.7            rise=1 targ v(out_above_57)   val=2.5 rise=1 td=129.900u
.endc
.end
