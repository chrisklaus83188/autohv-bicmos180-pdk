* Nominal operating point - NMOS1V8 at the TT corner
.include "../autohv_bicmos180_case.lib"
.param case=0          ; TT corner
.param PROC_ON=0       ; process variation off
.param MM_ON=0         ; mismatch off

Vdd d 0 1.8
Vg  g 0 1.8
X1  d g 0 0 NMOS1V8 W=10u L=1u M=1   ; d g s b

.op
.end
